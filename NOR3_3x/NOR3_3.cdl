************************************************************************
* auCdl Netlist:
*
* Library Name:  Lab1
* Top Cell Name: NOR3_3
* View Name:     schematic
* Netlisted on:  Apr 10 22:06:06 2026
************************************************************************

*.BIPOLAR
*.RESI = 2000
*.RESVAL
*.CAPVAL
*.DIOPERI
*.DIOAREA
*.EQUATION
*.SCALE METER
*.MEGA
.PARAM

*.GLOBAL gnd!
+        vdd!

*.PIN gnd!
*+    vdd!

************************************************************************
* Library Name: Lab1
* Cell Name:    NOR3_3
* View Name:    schematic
************************************************************************

.SUBCKT NOR3_3 A B C Q
*.PININFO A:I B:I C:I Q:O
MM2 Q C net8 vdd! P l=180.0n w=60u m=1
MM1 net8 B net4 vdd! P l=180.0n w=60u m=1
MM0 net4 A vdd! vdd! P l=180.0n w=60u m=1
MM5 Q C gnd! gnd! N l=180.0n w=1.5u m=1
MM4 Q B gnd! gnd! N l=180.0n w=1.5u m=1
MM3 Q A gnd! gnd! N l=180.0n w=1.5u m=1
.ENDS
