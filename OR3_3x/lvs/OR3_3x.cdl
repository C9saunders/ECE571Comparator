************************************************************************
* auCdl Netlist:
*
* Library Name:  ECE571_10_OR3
* Top Cell Name: OR3_3x
* View Name:     schematic
* Netlisted on:  Apr 10 15:15:45 2026
************************************************************************

*.BIPOLAR
*.RESI = 2000
*.RESVAL
*.CAPVAL
*.DIOPERI
*.DIOAREA
*.EQUATION
*.SCALE METER
*.MEGA
.PARAM

*.GLOBAL vdd!
+        vss!

*.PIN vdd!
*+    vss!

************************************************************************
* Library Name: ECE571_10_OR3
* Cell Name:    OR3_3x
* View Name:    schematic
************************************************************************

.SUBCKT OR3_3x A B C F vdd! vss!
*.PININFO A:I B:I C:I F:O vdd!:B vss!:B
MM5 F net3 vss! vss! N l=180.0n w=2u m=2
MM3 net3 A vss! vss! N l=180.0n w=2.5u m=2
MM4 net3 B vss! vss! N l=180.0n w=2.5u m=2
MM6 net3 C vss! vss! N l=180.0n w=2.5u m=2
MM1 net018 B net5 vdd! P l=180.0n w=3.75u m=4
MM0 net5 A vdd! vdd! P l=180.0n w=3.75u m=4
MM7 net3 C net018 vdd! P l=180.0n w=3.75u m=4
MM2 F net3 vdd! vdd! P l=180.0n w=6u m=2
.ENDS
