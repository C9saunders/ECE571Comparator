ADE simulation setup
Test Lab_01_OR2_5x_1: Lab_01/OR2_5x/schematic, simulator spectre
  Models: /top/students/UNGRAD/UE/tom2002/home/ECE571/TSMC_Cadence/tsmc18rf/rf018.scs[tt]
  Temperature: 27
  Analysis tran: stop=400n
  Signals: /inA, /inB, /out
