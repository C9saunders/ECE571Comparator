ADE simulation setup
Run mode: Single Run, Sweeps and Corners
Tests:
  Lab_01_OR2_6x_1: Lab_01/OR2_6x/schematic, simulator spectre
