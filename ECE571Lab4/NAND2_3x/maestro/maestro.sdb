ADE simulation setup
Run mode: Single Run, Sweeps and Corners
Tests:
  ECE571_NAND2_3x_1: ECE571/NAND2_3x/layout, simulator spectre
