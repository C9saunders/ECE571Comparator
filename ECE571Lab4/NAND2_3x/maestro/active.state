ADE simulation setup
Test ECE571_NAND2_3x_1: ECE571/NAND2_3x/layout, simulator spectre
  Models: /top/students/UNGRAD/ECE/jacobzp/home/ECE571/TSMC_Cadence/tsmc18rf/rf018.scs[tt]
  Temperature: 27
Run mode: Single Run, Sweeps and Corners
