ADE simulation setup
Run mode: Single Run, Sweeps and Corners
Tests:
  ECE571_9_NOR2_Comparator8bit_testbench_1: ECE571_9_NOR2/Comparator8bit_testbench/schematic, simulator spectre
