************************************************************************
* auCdl Netlist:
*
* Library Name:  KaiLab1
* Top Cell Name: AND3_3x
* View Name:     schematic
* Netlisted on:  Apr 15 17:17:34 2026
************************************************************************

*.BIPOLAR
*.RESI = 2000
*.RESVAL
*.CAPVAL
*.DIOPERI
*.DIOAREA
*.EQUATION
*.SCALE METER
*.MEGA
.PARAM

*.GLOBAL vdd!
+        gnd!

*.PIN vdd!
*+    gnd!

************************************************************************
* Library Name: KaiLab1
* Cell Name:    AND3_3x
* View Name:    schematic
************************************************************************

.SUBCKT AND3_3x A B C Q
*.PININFO A:I B:I C:I Q:O
MM6 Q net1 vdd! vdd! P l=180.0n w=4u m=3
MM2 net1 C vdd! vdd! P l=180.0n w=4u m=1
MM1 net1 B vdd! vdd! P l=180.0n w=4u m=1
MM0 net1 A vdd! vdd! P l=180.0n w=4u m=1
MM7 Q net1 gnd! gnd! N l=180.0n w=4u m=1
MM5 net2 C gnd! gnd! N l=180.0n w=4u m=1
MM4 net1 A net5 gnd! N l=180.0n w=4u m=1
MM3 net5 B net2 gnd! N l=180.0n w=4u m=1
.ENDS
