ADE simulation setup
Test ECE571_9_NOR2_Comparator8bit_testbench_1: ECE571_9_NOR2/Comparator8bit_testbench/schematic, simulator spectre
  Models: /top/students/UNGRAD/ECE/tiger131/home/ECE331/TSMC_Cadence/tsmc18rf/rf018.scs[tt]
  Temperature: 27
  Analysis tran: stop=8u errpreset=moderate
  Signals: /net31, /net23, /net20, /net39, /net38, /net37
