ADE simulation setup
Run mode: Single Run, Sweeps and Corners
Tests:
  ECE571_ComparatorTestbench_1: ECE571/ComparatorTestbench/schematic, simulator spectre
