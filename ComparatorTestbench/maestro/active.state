ADE simulation setup
Test ECE571_ComparatorTestbench_1: ECE571/ComparatorTestbench/schematic, simulator spectre
  Models: /top/students/UNGRAD/ECE/tiger131/home/ECE331/TSMC_Cadence/tsmc18rf/rf018.scs[tt]
  Temperature: 27
  Analysis tran: stop=4u errpreset=moderate
  Signals: /net14, /net6, /net22, /net21, /net20
Run mode: Single Run, Sweeps and Corners
