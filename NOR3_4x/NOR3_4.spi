* +++++++++++++++++++++++++++++++++++++++++++++++++++++++++ *
* CDL Netlist:                                              *
*                                                           *
* Cell Name  : NOR3_4                                       *
* Netlisted  : Thu Apr 16 22:37:51 2026                     *
* Pegasus Version: 23.14-s006 Thu Jan 25 18:41:38 PST 2024  *
* +++++++++++++++++++++++++++++++++++++++++++++++++++++++++ *
*.LDD
*.DEVTMPLT 0 MN(N) ngate tndiff(D) poly(G) tndiff(S) psub(B)
*.DEVTMPLT 1 MP(P) pgate tpdiff(D) poly(G) tpdiff(S) nxwell(B)

* +++++++++++++++++++++++++++++++++++++++++++++++++++++++++ *
* Sub cell: NOR3_4                                          *
* +++++++++++++++++++++++++++++++++++++++++++++++++++++++++ *
.subckt NOR3_4 A B C Q gnd! vdd!
** N=8 EP=6 FDC=48
M0 Q A gnd! gnd! N L=1.8e-07 W=5e-07 $X=940 $Y=1640 $dt=0
M1 gnd! A Q gnd! N L=1.8e-07 W=5e-07 $X=1820 $Y=1640 $dt=0
M2 Q A gnd! gnd! N L=1.8e-07 W=5e-07 $X=2630 $Y=1640 $dt=0
M3 gnd! A Q gnd! N L=1.8e-07 W=5e-07 $X=3450 $Y=1640 $dt=0
M4 Q B gnd! gnd! N L=1.8e-07 W=5e-07 $X=12740 $Y=1640 $dt=0
M5 gnd! B Q gnd! N L=1.8e-07 W=5e-07 $X=13620 $Y=1640 $dt=0
M6 Q B gnd! gnd! N L=1.8e-07 W=5e-07 $X=14450 $Y=1640 $dt=0
M7 gnd! B Q gnd! N L=1.8e-07 W=5e-07 $X=15270 $Y=1640 $dt=0
M8 Q C gnd! gnd! N L=1.8e-07 W=5e-07 $X=24590 $Y=1640 $dt=0
M9 gnd! C Q gnd! N L=1.8e-07 W=5e-07 $X=25470 $Y=1640 $dt=0
M10 Q C gnd! gnd! N L=1.8e-07 W=5e-07 $X=26300 $Y=1640 $dt=0
M11 gnd! C Q gnd! N L=1.8e-07 W=5e-07 $X=27120 $Y=1640 $dt=0
M12 6 A vdd! vdd! P L=1.8e-07 W=7.5e-06 $X=940 $Y=5280 $dt=1
M13 vdd! A 6 vdd! P L=1.8e-07 W=7.5e-06 $X=1800 $Y=5280 $dt=1
M14 6 A vdd! vdd! P L=1.8e-07 W=7.5e-06 $X=2660 $Y=5280 $dt=1
M15 vdd! A 6 vdd! P L=1.8e-07 W=7.5e-06 $X=3520 $Y=5280 $dt=1
M16 6 A vdd! vdd! P L=1.8e-07 W=7.5e-06 $X=4380 $Y=5280 $dt=1
M17 vdd! A 6 vdd! P L=1.8e-07 W=7.5e-06 $X=5240 $Y=5280 $dt=1
M18 6 A vdd! vdd! P L=1.8e-07 W=7.5e-06 $X=6100 $Y=5280 $dt=1
M19 vdd! A 6 vdd! P L=1.8e-07 W=7.5e-06 $X=6960 $Y=5280 $dt=1
M20 6 A vdd! vdd! P L=1.8e-07 W=7.5e-06 $X=7820 $Y=5280 $dt=1
M21 vdd! A 6 vdd! P L=1.8e-07 W=7.5e-06 $X=8680 $Y=5280 $dt=1
M22 6 A vdd! vdd! P L=1.8e-07 W=7.5e-06 $X=9540 $Y=5280 $dt=1
M23 vdd! A 6 vdd! P L=1.8e-07 W=7.5e-06 $X=10400 $Y=5280 $dt=1
M24 7 B 6 vdd! P L=1.8e-07 W=7.5e-06 $X=12700 $Y=4890 $dt=1
M25 6 B 7 vdd! P L=1.8e-07 W=7.5e-06 $X=13560 $Y=4890 $dt=1
M26 7 B 6 vdd! P L=1.8e-07 W=7.5e-06 $X=14420 $Y=4890 $dt=1
M27 6 B 7 vdd! P L=1.8e-07 W=7.5e-06 $X=15280 $Y=4890 $dt=1
M28 7 B 6 vdd! P L=1.8e-07 W=7.5e-06 $X=16140 $Y=4890 $dt=1
M29 6 B 7 vdd! P L=1.8e-07 W=7.5e-06 $X=17000 $Y=4890 $dt=1
M30 7 B 6 vdd! P L=1.8e-07 W=7.5e-06 $X=17860 $Y=4890 $dt=1
M31 6 B 7 vdd! P L=1.8e-07 W=7.5e-06 $X=18720 $Y=4890 $dt=1
M32 7 B 6 vdd! P L=1.8e-07 W=7.5e-06 $X=19580 $Y=4890 $dt=1
M33 6 B 7 vdd! P L=1.8e-07 W=7.5e-06 $X=20440 $Y=4890 $dt=1
M34 7 B 6 vdd! P L=1.8e-07 W=7.5e-06 $X=21300 $Y=4890 $dt=1
M35 6 B 7 vdd! P L=1.8e-07 W=7.5e-06 $X=22160 $Y=4890 $dt=1
M36 Q C 7 vdd! P L=1.8e-07 W=7.5e-06 $X=24620 $Y=4890 $dt=1
M37 7 C Q vdd! P L=1.8e-07 W=7.5e-06 $X=25480 $Y=4890 $dt=1
M38 Q C 7 vdd! P L=1.8e-07 W=7.5e-06 $X=26340 $Y=4890 $dt=1
M39 7 C Q vdd! P L=1.8e-07 W=7.5e-06 $X=27130 $Y=4890 $dt=1
M40 Q C 7 vdd! P L=1.8e-07 W=7.5e-06 $X=28060 $Y=4890 $dt=1
M41 7 C Q vdd! P L=1.8e-07 W=7.5e-06 $X=28920 $Y=4890 $dt=1
M42 Q C 7 vdd! P L=1.8e-07 W=7.5e-06 $X=29780 $Y=4890 $dt=1
M43 7 C Q vdd! P L=1.8e-07 W=7.5e-06 $X=30640 $Y=4890 $dt=1
M44 Q C 7 vdd! P L=1.8e-07 W=7.5e-06 $X=31510 $Y=4890 $dt=1
M45 7 C Q vdd! P L=1.8e-07 W=7.5e-06 $X=32370 $Y=4890 $dt=1
M46 Q C 7 vdd! P L=1.8e-07 W=7.5e-06 $X=33230 $Y=4890 $dt=1
M47 7 C Q vdd! P L=1.8e-07 W=7.5e-06 $X=34090 $Y=4890 $dt=1
.ends NOR3_4
