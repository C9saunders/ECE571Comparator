* +++++++++++++++++++++++++++++++++++++++++++++++++++++++++ *
* CDL Netlist:                                              *
*                                                           *
* Cell Name  : NOR3_3                                       *
* Netlisted  : Thu Apr 16 22:46:00 2026                     *
* Pegasus Version: 23.14-s006 Thu Jan 25 18:41:38 PST 2024  *
* +++++++++++++++++++++++++++++++++++++++++++++++++++++++++ *
*.LDD
*.DEVTMPLT 0 MN(N) ngate tndiff(D) poly(G) tndiff(S) psub(B)
*.DEVTMPLT 1 MP(P) pgate tpdiff(D) poly(G) tpdiff(S) nxwell(B)

* +++++++++++++++++++++++++++++++++++++++++++++++++++++++++ *
* Sub cell: NOR3_3                                          *
* +++++++++++++++++++++++++++++++++++++++++++++++++++++++++ *
.subckt NOR3_3 A B C Q gnd! vdd!
** N=8 EP=6 FDC=30
M0 Q A gnd! gnd! N L=1.8e-07 W=7.5e-07 $X=940 $Y=1640 $dt=0
M1 gnd! A Q gnd! N L=1.8e-07 W=7.5e-07 $X=1820 $Y=1640 $dt=0
M2 Q B gnd! gnd! N L=1.8e-07 W=7.5e-07 $X=9270 $Y=1640 $dt=0
M3 gnd! B Q gnd! N L=1.8e-07 W=7.5e-07 $X=10150 $Y=1640 $dt=0
M4 Q C gnd! gnd! N L=1.8e-07 W=7.5e-07 $X=17530 $Y=1640 $dt=0
M5 gnd! C Q gnd! N L=1.8e-07 W=7.5e-07 $X=18410 $Y=1640 $dt=0
M6 7 A vdd! vdd! P L=1.8e-07 W=7.5e-06 $X=940 $Y=5280 $dt=1
M7 vdd! A 7 vdd! P L=1.8e-07 W=7.5e-06 $X=1800 $Y=5280 $dt=1
M8 7 A vdd! vdd! P L=1.8e-07 W=7.5e-06 $X=2660 $Y=5280 $dt=1
M9 vdd! A 7 vdd! P L=1.8e-07 W=7.5e-06 $X=3520 $Y=5280 $dt=1
M10 7 A vdd! vdd! P L=1.8e-07 W=7.5e-06 $X=4380 $Y=5280 $dt=1
M11 vdd! A 7 vdd! P L=1.8e-07 W=7.5e-06 $X=5240 $Y=5280 $dt=1
M12 7 A vdd! vdd! P L=1.8e-07 W=7.5e-06 $X=6100 $Y=5280 $dt=1
M13 vdd! A 7 vdd! P L=1.8e-07 W=7.5e-06 $X=6960 $Y=5280 $dt=1
M14 8 B 7 vdd! P L=1.8e-07 W=7.5e-06 $X=9230 $Y=4890 $dt=1
M15 7 B 8 vdd! P L=1.8e-07 W=7.5e-06 $X=10090 $Y=4890 $dt=1
M16 8 B 7 vdd! P L=1.8e-07 W=7.5e-06 $X=10950 $Y=4890 $dt=1
M17 7 B 8 vdd! P L=1.8e-07 W=7.5e-06 $X=11810 $Y=4890 $dt=1
M18 8 B 7 vdd! P L=1.8e-07 W=7.5e-06 $X=12670 $Y=4890 $dt=1
M19 7 B 8 vdd! P L=1.8e-07 W=7.5e-06 $X=13530 $Y=4890 $dt=1
M20 8 B 7 vdd! P L=1.8e-07 W=7.5e-06 $X=14390 $Y=4890 $dt=1
M21 7 B 8 vdd! P L=1.8e-07 W=7.5e-06 $X=15250 $Y=4890 $dt=1
M22 Q C 8 vdd! P L=1.8e-07 W=7.5e-06 $X=17490 $Y=4890 $dt=1
M23 8 C Q vdd! P L=1.8e-07 W=7.5e-06 $X=18350 $Y=4890 $dt=1
M24 Q C 8 vdd! P L=1.8e-07 W=7.5e-06 $X=19210 $Y=4890 $dt=1
M25 8 C Q vdd! P L=1.8e-07 W=7.5e-06 $X=20070 $Y=4890 $dt=1
M26 Q C 8 vdd! P L=1.8e-07 W=7.5e-06 $X=20930 $Y=4890 $dt=1
M27 8 C Q vdd! P L=1.8e-07 W=7.5e-06 $X=21790 $Y=4890 $dt=1
M28 Q C 8 vdd! P L=1.8e-07 W=7.5e-06 $X=22650 $Y=4890 $dt=1
M29 8 C Q vdd! P L=1.8e-07 W=7.5e-06 $X=23510 $Y=4890 $dt=1
.ends NOR3_3
