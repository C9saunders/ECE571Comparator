ADE simulation setup
Run mode: Single Run, Sweeps and Corners
Tests:
  Lab_01_OR2_5x_1: Lab_01/OR2_5x/schematic, simulator spectre
