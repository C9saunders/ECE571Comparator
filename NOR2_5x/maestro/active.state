ADE simulation setup
Test Lab1_OR_2_5_1: Lab1/OR_2_5/layout, simulator spectre
  Models: /top/students/GRAD/ME/C837691156/home/ECE_571/TSMC_Cadence/tsmc18rf/rf018.scs[tt]
  Temperature: 27
  Analysis tran: stop=10n
Run mode: Single Run, Sweeps and Corners
