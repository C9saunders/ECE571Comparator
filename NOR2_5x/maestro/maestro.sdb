ADE simulation setup
Run mode: Single Run, Sweeps and Corners
Tests:
  Lab1_OR_2_5_1: Lab1/OR_2_5/layout, simulator spectre
