************************************************************************
* auCdl Netlist:
*
* Library Name:  Lab1
* Top Cell Name: OR_2_5
* View Name:     schematic
* Netlisted on:  Mar 18 21:04:38 2026
************************************************************************

*.BIPOLAR
*.RESI = 2000
*.RESVAL
*.CAPVAL
*.DIOPERI
*.DIOAREA
*.EQUATION
*.SCALE METER
*.MEGA
.PARAM

*.GLOBAL gnd!
+        vdd!

*.PIN gnd!
*+    vdd!

************************************************************************
* Library Name: Lab1
* Cell Name:    OR_2_5
* View Name:    schematic
************************************************************************

.SUBCKT OR_2_5 A B Out
*.PININFO A:I B:I Out:O
MM1 Out B net4 vdd! P l=180.0n w=49.98u m=1
MM0 net4 A vdd! vdd! P l=180.0n w=49.98u m=1
MM3 Out A gnd! gnd! N l=180.0n w=7u m=1
MM2 Out B gnd! gnd! N l=180.0n w=7u m=1
.ENDS
