************************************************************************
* auCdl Netlist:
*
* Library Name:  Lab1
* Top Cell Name: AND3_1x
* View Name:     schematic
* Netlisted on:  Apr 17 15:42:17 2026
************************************************************************

*.BIPOLAR
*.RESI = 2000
*.RESVAL
*.CAPVAL
*.DIOPERI
*.DIOAREA
*.EQUATION
*.SCALE METER
*.MEGA
.PARAM

*.GLOBAL vdd!
+        gnd!

*.PIN vdd!
*+    gnd!

************************************************************************
* Library Name: Lab1
* Cell Name:    AND3_1x
* View Name:    schematic
************************************************************************

.SUBCKT AND3_1x A B C Q
*.PININFO A:I B:I C:I Q:O
MM7 Q net1 gnd! gnd! N l=180.0n w=1u m=1
MM13 net1 A net3 gnd! N l=180.0n w=1.5u m=1
MM11 net4 C gnd! gnd! N l=180.0n w=1.5u m=1
MM12 net3 B net4 gnd! N l=180.0n w=1.5u m=1
MM6 Q net1 vdd! vdd! P l=180.0n w=3.2u m=1
MM8 net1 B vdd! vdd! P l=180.0n w=500n m=1
MM9 net1 A vdd! vdd! P l=180.0n w=500n m=1
MM10 net1 C vdd! vdd! P l=180.0n w=500n m=1
.ENDS
