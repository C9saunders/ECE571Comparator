************************************************************************
* auCdl Netlist:
*
* Library Name:  Lab1
* Top Cell Name: AND3_2x
* View Name:     schematic
* Netlisted on:  Apr 17 21:14:56 2026
************************************************************************

*.BIPOLAR
*.RESI = 2000
*.RESVAL
*.CAPVAL
*.DIOPERI
*.DIOAREA
*.EQUATION
*.SCALE METER
*.MEGA
.PARAM

************************************************************************
* Library Name: Lab1
* Cell Name:    AND3_2x
* View Name:    schematic
************************************************************************

.SUBCKT AND3_2x A B C Q vdd vss
*.PININFO A:I B:I C:I Q:O vdd:B vss:B
MM7 Q net1 vss vss N l=180.0n w=1.9u m=1
MM13 net1 A net3 vss N l=180.0n w=5.7u m=1
MM11 net2 C vss vss N l=180.0n w=5.7u m=1
MM12 net3 B net2 vss N l=180.0n w=5.7u m=1
MM6 Q net1 vdd vdd P l=180.0n w=6.08u m=1
MM8 net1 B vdd vdd P l=180.0n w=1.9u m=1
MM9 net1 A vdd vdd P l=180.0n w=1.9u m=1
MM10 net1 C vdd vdd P l=180.0n w=1.9u m=1
.ENDS
